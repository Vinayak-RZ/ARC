* vcvs
V1 1 0 DC 5
R1 1 2 2k
R2 2 0 2k
E1 3 0 2 0 10
R3 3 0 1k
.end
