* rl ac
I1 0 1 AC 1
R1 1 0 220
L1 1 0 50m
.ac lin 1 50 50
.end
