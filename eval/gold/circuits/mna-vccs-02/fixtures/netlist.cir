* vccs
V1 1 0 DC 5
R1 1 2 2k
G1 3 0 1 2 0.02
R2 3 0 3k
.end
