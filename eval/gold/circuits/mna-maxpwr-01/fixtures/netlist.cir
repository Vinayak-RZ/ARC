* maxp
V1 1 0 DC 12
R1 1 2 2k
R2 2 0 2k
.end
