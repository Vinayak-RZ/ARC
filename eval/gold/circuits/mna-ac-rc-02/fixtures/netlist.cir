* rc ac
V1 1 0 AC 5
R1 1 2 470
C1 2 0 2.2u
.ac lin 1 100 100
.end
