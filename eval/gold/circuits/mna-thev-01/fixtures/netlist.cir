* thev
V1 1 0 DC 15
R1 1 2 2k
R2 2 0 3k
R3 2 3 1k
R4 3 0 4.7k
.end
