* rlc od
I1 0 3 DC 0
R1 1 2 200
L1 2 3 5m
C1 3 0 500n
.ic v(3)=0
.tran 10u 0.001
.end
