* rc tran
V1 1 0 DC 10
R1 1 2 10k
C1 2 0 10u
.tran 1m 0.1
.end
