* mesh
I1 0 1 DC 0.002
R1 1 2 2k
R2 2 0 3k
R3 2 3 1.5k
R4 3 4 2.5k
R5 4 0 1k
.end
