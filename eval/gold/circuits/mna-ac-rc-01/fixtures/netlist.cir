* rc ac
V1 1 0 AC 10
R1 1 2 1k
C1 2 0 1u
.ac lin 1 159.15 159.15
.end
