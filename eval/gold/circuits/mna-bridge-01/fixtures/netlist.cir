* bridge
V1 1 0 DC 10
R1 1 2 1k
R2 2 4 1k
R3 1 3 1k
R4 3 4 1k
R5 2 3 500
R6 4 0 500
.end
