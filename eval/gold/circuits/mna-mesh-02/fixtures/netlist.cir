* mesh
I1 0 1 DC 0.005
R1 1 2 1k
R2 2 0 2k
R3 2 3 1k
R4 3 0 500
.end
