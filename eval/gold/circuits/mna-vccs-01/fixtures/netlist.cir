* vccs
V1 1 0 DC 5
R1 1 2 1k
R2 2 0 1k
G1 3 0 1 2 0.01
R3 3 0 2k
.end
