* z11
I1 0 1 DC 1
R1 1 2 100
R2 2 0 300
R3 2 0 600
.end
