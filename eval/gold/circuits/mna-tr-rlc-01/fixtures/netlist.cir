* rlc
R1 1 2 50
L1 2 3 1m
C1 3 0 1u
.ic v(3)=10
.tran 1u 0.0001
.end
